addrmap simple_test {
    reg {
        field {
            sw=rw;
            hw=r;
        } data[31:0];
    } test_reg @ 0x0;
};