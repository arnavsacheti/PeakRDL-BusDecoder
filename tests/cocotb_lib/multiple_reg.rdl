addrmap multi_reg {
    reg {
        field {
            sw=rw;
            hw=r;
        } data[31:0];
    } reg1 @ 0x0;

    reg {
        field {
            sw=r;
            hw=w;
        } status[15:0];
    } reg2 @ 0x4;

    reg {
        field {
            sw=rw;
            hw=r;
        } control[7:0];
    } reg3 @ 0x8;
};